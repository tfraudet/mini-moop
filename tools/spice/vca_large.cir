VCA (circuit 7): tail currents and large-signal transfer at a 1 kHz sine
.include models.lib
.include board4-vca.lib
.options temp=25 tnom=25
vp vp 0 10
vn vn 0 -10
vin in 0 dc 0 sin(0 1 1k)
vcont cont 0 5
vl lsrc 0 10
r56 lsrc loud 33k
va a440 0 0
x1 in cont loud a440 out vp vn vca
c2 out o2 10u
r75 o2 jack 1k
r20 jack 0 5k
.control
op
print @q.x1.q18[ic] @q.x1.q21[ic] @q.x1.q1[ic] v(x1.e1) v(x1.e2) v(x1.c16) v(x1.c14) v(out)
foreach vc 1 2 3 4 4.5 5 5.5
  alter vcont dc = $vc
  op
  print @q.x1.q18[ic]
end
alter vcont dc = 5
foreach amp 0.25 0.5 1 2 4 8
  alter @vin[sin] = [ 0 $amp 1k ]
  tran 5u 40m 30m
  meas tran hi max v(out)
  meas tran lo min v(out)
  meas tran jhi max v(jack)
  meas tran jlo min v(jack)
end
.endc
.end
