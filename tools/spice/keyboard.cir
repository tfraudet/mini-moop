keyboard track and hold (circuit 1): the amplifier's rails and gain, the glide, the hold
.include models.lib
.include board2-keyboard.lib
.options temp=25 tnom=25 reltol=1e-4 abstol=1e-13
.param rglide=5meg
vp vp 0 10
vn vn 0 -10
* the key: 1 V, then 2 V at 0.1 s, back to 1 V at 2.6 s; the trigger bus on a 1 ohm switch
vkey kv 0 pwl(0 1 0.1 1 0.1001 2 2.6 2 2.6001 1)
rkey kv pitch 100
vtr trig 0 pwl(0 10 5.0 10 5.0001 -10)
x1 pitch trig g8 g7 out vp vn keyboard
rg g8 g7 {rglide}
.control
tran 1m 6.5 uic
meas tran v0 find v(out) at=0.09
meas tran koup find v(x1.ko) at=0.3
meas tran kodn find v(x1.ko) at=2.8
meas tran t05u when v(out)=1.05 rise=1
meas tran t95u when v(out)=1.95 rise=1
meas tran t95d when v(out)=1.95 fall=1
meas tran t05d when v(out)=1.05 fall=1
meas tran vhold1 find v(out) at=5.1
meas tran vhold2 find v(out) at=6.4
meas tran c6v find v(x1.hold) at=4.9
meas tran outv find v(out) at=4.9
meas tran c6hi find v(x1.hold) at=2.5
meas tran outhi find v(out) at=2.5
let fgain = (outhi - outv) / (c6hi - c6v)
let foff = outv - fgain * c6v
let up = (t95u-t05u)/0.9
let dn = (t05d-t95d)/0.9
let sag = (vhold2-vhold1)/1.3*1200*60
echo "amplifier saturated: $&koup V going up, $&kodn V going down"
echo "GLIDE 5M: $&up s an octave up, $&dn s down"
echo "follower: C6 $&c6v V for $&outv V out, $&c6hi V for $&outhi V: out = $&fgain C6 + $&foff; hold sag $&sag cents a minute"
.endc
.end
