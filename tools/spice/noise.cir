noise generator (circuit 3): pink and red against white
.include models.lib
.include board3-noise.lib
.options temp=25 tnom=25
vp vp 0 10
vw white 0 dc 0 ac 1
x1 white pink red vp noisefilters
* the pink output's load: C20 2.5 uF into the NOISE VOLUME pot (25K) or MODULATION MIX (24K)
c20 pink po 2.5u
rl po 0 25k
.control
op
print v(pink) v(x1.b3) v(x1.e3) @q.x1.q3[ic]
ac dec 3 20 20k
print vdb(po) vdb(red)
* Q3's gain from its base and its input resistance at 1 kHz
ac lin 1 1k 1k
* C1's current is (v(p) - v(b3)) j w C1: ngspice cannot probe a capacitor's current directly
let gain = mag(v(po)/v(x1.b3))
let ic1 = mag((v(x1.p) - v(x1.b3)) * 2 * pi * 1k * 2.5u)
let rin = mag(v(x1.b3)) / ic1
print gain rin mag(v(x1.p))
.endc
.end
